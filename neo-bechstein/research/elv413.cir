Siemens ELV413 / Vienna - Wittig fig.8, values effective estimates from fig.10
.param MASTER=.46 CSW=700p AMP=.141421356237
Vsig e1 0 dc 0 ac 1 sin(0 {AMP} 1k)
Cin e1 g1 22n
Rg1 g1 0 1meg
Cwire e1 0 50p
G1 p1 0 g1 0 .0035
Rplate1 p1 0 7142.857142857
Rstop1 p1 a1 4.7k
Rload1 a1 0 68k
Csw1 a1 sw 300n
Rsw1 sw 0 1meg
CSW sw g2 {CSW}
Rsw2 g2 0 1meg
Csw2 g2 0 5.87n
G2 p2 0 g2 0 .0035
Rplate2 p2 0 7142.857142857
Rstop2 p2 a2 4.7k
Rload2 a2 0 68k
Cm a2 top 100n
Rp2hi top w {max(.001,250000*(1-MASTER))}
Rp2lo w 0 {max(.001,250000*MASTER)}
Cg3 w g3 22n
Rg3 g3 0 1meg
.func power15(x) {max(x,0)*sqrt(max(x,0))}
Bdriver p3 0 I=.002*(min(power15(1+(v(g3)+v(p3)/25)*.0035/.003),power15((120+v(p3))/18))-1)
Rload3 p3 0 68k
Ctt p3 tt_hot 673n
Rtt tt_hot winding 300
Lleak winding core 2.27
Cfeed winding core 119p
Rloss_w winding core 1.68meg
Lmag core 0 9.78
Cw core 0 10p
Rcore core 0 780k
Ett1 ga 0 core 0 .82
Ett2 gb 0 core 0 -.82
Ftt1 core 0 Ett1 -.82
Ftt2 core 0 Ett2 .82
BgridA ga 0 I=max(0,v(ga)-45)/330
BgridB gb 0 I=max(0,v(gb)-45)/330
.func itri(vg,vp) {.04*(min(power15(1+(vg+vp/3.4)*.0025/.06),power15((250+vp)/28))-1)}
Bouta pa 0 I=itri(v(ga),v(pa))
Boutb pb 0 I=itri(v(gb),v(pb))
Rha pa ha 100
Rhb pb hb 100
Eat1 ha 0 ar 0 14.4
Eat2 hb 0 ar 0 -14.4
Fat1 ar 0 Eat1 -14.4
Fat2 ar 0 Eat2 14.4
Louth ar 0 .3
Rout ar als .30
Loutleak als out 68.9u
Cout out 0 3.01u
Rspk out 0 6
